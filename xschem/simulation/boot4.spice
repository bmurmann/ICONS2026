** sch_path: /foss/designs/ICONS2026/xschem/boot4.sch
**.subckt boot4 vdd p1 p2 vo vi
*.ipin vi
*.opin vo
*.ipin p2
*.iopin vdd
*.ipin p1
Cm1 vtop vbot cb m=1
XM1 vi vg vo GND sg13_lv_nmos w=w l=0.13u ng=ng m=1
XM8 vg vdd net1 GND sg13_lv_nmos w=w4 l=0.13u ng=ng4 m=1
XM4 net1 p2 GND GND sg13_lv_nmos w=w4 l=0.13u ng=ng4 m=1
XM6 vbot p2 GND GND sg13_lv_nmos w=w6 l=0.13u ng=1 m=1
XM5 vtop vg vdd vtop sg13_lv_pmos w=w5 l=0.13u ng=1 m=1
Cw6 vtop GND cw5+cw2 m=1
XM3 vbot vg vi GND sg13_lv_nmos w=w3 l=0.13u ng=1 m=1
S3 vg vtop p1 GND SW1
**.ends
.GLOBAL GND
**** begin user architecture code
.MODEL SW1 SW
+ VT=0.6 VH=vh
+ RON=rsw ROFF=roff
**** end user architecture code
.end
