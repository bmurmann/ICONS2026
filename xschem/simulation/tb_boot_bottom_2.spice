** sch_path: /foss/designs/ICONS2026/xschem/tb_boot_bottom_2.sch
**.subckt tb_boot_bottom_2
Vi2 net1 GND sin({viq} vamp fin 0)
x1 net3 VDD VSS p2 sg13g2_inv_4
x2 net2 VDD VSS p1 sg13g2_inv_4
x3 trackb net2 VDD VSS net3 sg13g2_nand2_2
x4 net3 track VDD VSS net2 sg13g2_nand2_2
x5 track VDD VSS trackb sg13g2_inv_2
Vtrk net4 GND pulse(0 vdd 0 trf trf {per/2} per 0)
Vsup vdd GND vdd
Vsup1 vss GND 0
R1 net1 vi rs m=1
Cp vc votap cl m=1
G1 vo GND votap GND 100e-3
S7 vo vc p2 GND SW1
Cp3 vo GND cl m=1
S8 votap GND track GND SW1
S10 vo GND p1 GND SW1
Cp5 votap GND 100f m=1
x6 vdd p1 p2 vc vi boot2
R2 track net4 1k m=1
**** begin user architecture code

.lib cornerMOSlv.lib mos_tt
.inc /foss/pdks/ihp-sg13g2/libs.ref/sg13g2_stdcell/spice/sg13g2_stdcell.spice
.param vdd=1.2 viq=0.6 vamp=0.3
.param cl=1.3p cb=1p cp=50f w=26u ng=5
.param w4=13u ng4=3
.param ndft=31 npad=5 bin=5 fclk=500e6 runs=15
.param per=1/fclk fin=fclk*bin/ndft trf=100p
.param vh=0 rsw=10 roff=1e9 rs=10

.csparam per=per runs=runs
.csparam tstop1 = 4*per
.csparam tstop2 = per*(ndft+npad)
.option method=trap reltol=1e-5 chgtol=1e-16

.control
    tran 1n $&tstop1
    write tb_boot_bottom_2.raw
    option numdgt=9
    set wr_singlescale
    set wr_vecnames
    compose bin_vec start=1 stop=$&runs step=1
    foreach i $&bin_vec
      alterparam bin=$i
      reset
      tran 10p $&tstop2 0
      let lin-tstep = $&per
      let lin-tstart = 1.9n
      linearize
      wrdata tb_boot_bottom_2.txt v(vi) v(vo)
      destroy all
      set appendwrite
      unset wr_vecnames
    end
    unset appendwrite
.endc

**** end user architecture code
**.ends

* expanding   symbol:  boot2.sym # of pins=5
** sym_path: /foss/designs/ICONS2026/xschem/boot2.sym
** sch_path: /foss/designs/ICONS2026/xschem/boot2.sch
.subckt boot2 vdd p1 p2 vo vi
*.ipin vi
*.opin vo
*.ipin p2
*.ipin p1
*.iopin vdd
Cm1 vtop vbot {cb} m=1
S1 vbot GND p2 GND SW1
S2 vdd vtop p2 GND SW1
S3 vg vtop p1 GND SW1
S4 vi vbot p1 GND SW1
XM1 vi vg vo GND sg13_lv_nmos w=w l=0.13u ng=ng m=1
XM8 vg vdd net1 GND sg13_lv_nmos w=w4 l=0.13u ng=ng4 m=1
XM4 net1 p2 GND GND sg13_lv_nmos w=w4 l=0.13u ng=ng4 m=1
Cm2 vg GND 15f m=1
.ends

.GLOBAL GND
**** begin user architecture code
.MODEL SW1 SW
+ VT=0.6 VH=vh
+ RON=rsw ROFF=roff
**** end user architecture code
.end
