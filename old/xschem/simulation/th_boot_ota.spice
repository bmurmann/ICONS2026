** sch_path: /foss/designs/ICONS2026/th_nmos/xschem/th_boot_ota.sch
**.subckt th_boot_ota track vip vop vom vim vss vdd
*.ipin vip
*.ipin vim
*.opin vom
*.ipin track
*.iopin vss
*.iopin vdd
*.opin vop
XMm vim track vom vss sg13_lv_nmos w={w/nf} l={l} ng=1 m=nf
Cm vom vss {cl}
Cm1 vtop vbot {cb}
S1 vbot vss ph vss SW1
S2 vdd vtop ph vss SW1
S3 vgp vtop pt vss SW1
S4 vip vbot pt vss SW1
S5 vss vgp ph vss SW1
V1 net3 vss vcm
V2 net4 net3 vdd
Cp1 ph vss 10f
Cp2 pt vss 10f
Cp vcp votap {cl}
S6 votap vss track_res vss SW1
G1 vop vss votap vss 100e-3
S7 vop vcp ph vss SW1
Cp3 vop vss {cl}
S8 vop vss pt vss SW1
x6 ph net2 VDD VSS sg13g2_inv_2
x4 pt net1 VDD VSS sg13g2_inv_2
x1 trackb track_res VDD VSS sg13g2_inv_2
x5 net2 trackb net1 VDD VSS sg13g2_nand2_2
x2 net1 net2 track_res VDD VSS sg13g2_nand2_2
Xmdum net3 net4 net3 vss sg13_lv_nmos w={w/nf} l={l} ng=1 m=nf
Cp4 vgp vss 100f
R1 track_res track 10
XMm1 vip vgp vcp vss sg13_lv_nmos w={w/nf} l={l} ng=1 m=nf
**.ends
**** begin user architecture code
.MODEL SW1 SW
+ VT=0.6 VH=vh
+ RON=rsw ROFF=10G
**** end user architecture code
.end
