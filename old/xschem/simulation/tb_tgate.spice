** sch_path: /foss/designs/ICONS2026/th_nmos/xschem/tb_tgate.sch
**.subckt tb_tgate
Vi vi GND 0.6
XM1 net1 vdd vi GND sg13_lv_nmos w=1.3u l=0.13u ng=1 m=1
XM2 net1 GND vi vdd sg13_lv_pmos w=3.9u l=0.13u ng=1 m=1
Vdd vdd GND 1.2
**** begin user architecture code

.lib cornerMOSlv.lib mos_tt

.save @n.xm1.nsg13_lv_nmos[gds]
.save @n.xm2.nsg13_lv_pmos[gds]
.save all
.dc Vi 0 1.2 0.01

.control
   run
   write tb_tgate.raw
   op
   show
.endc

**** end user architecture code
**.ends
.GLOBAL GND
.end
