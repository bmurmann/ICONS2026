** sch_path: /foss/designs/ICONS2026/th_nmos/xschem/tb_th_boot.sch
**.subckt tb_th_boot
E1 vsp vsc vsd GND 0.5
E2 vsm vsc vsd GND -0.5
Vcm vsc GND vcm
Vsup vdd GND vdd
Vdm vsd GND sin(0 vamp fin 0)
x1 track vip vop vom vim GND vdd th_boot
Rp vsp vip rs m=1
Rm vim vsm rs m=1
Vtrk track GND dc vdd pulse(0 vdd 0 trf trf {per/2} per 0)
**** begin user architecture code

.lib cornerMOSlv.lib mos_tt
.inc /foss/pdks/ihp-sg13g2/libs.ref/sg13g2_stdcell/spice/sg13g2_stdcell.spice
.param vdd=1.2 vcm=0.3 vamp=0.4
.param rs=1m cl=5p cb=5p w=50u l=0.13u nf=10
.param nfft=32 fclk=500Meg per=1/fclk trf=50p
.param bin=1 fin=fclk*bin/nfft

.csparam per = per
.csparam t1 = 4*per
.csparam tstart = 3/4*per
.csparam tstop = {3/4*per + per*(nfft+3)}
.option method=gear reltol=1e-6 delmax=1p

.control
    tran 1n $&t1
    write tb_th_boot.raw

    option interp
    set wr_singlescale
    set wr_vecnames
    compose bin_vec start=1 stop=15 step=1
    foreach i $&bin_vec
      alterparam bin=$i
      reset
      tran $&per $&tstop $&tstart
      wrdata tb_th_boot.txt v(vop)
      set appendwrite
      unset set wr_vecnames
    end
    unset appendwrite
    op
    show n.x1.xmdum.nsg13_lv_nmos
.endc

**** end user architecture code
**.ends

* expanding   symbol:  th_boot.sym # of pins=7
** sym_path: /foss/designs/ICONS2026/th_nmos/xschem/th_boot.sym
** sch_path: /foss/designs/ICONS2026/th_nmos/xschem/th_boot.sch
.subckt th_boot track vip vop vom vim vss vdd
*.ipin vip
*.opin vop
*.ipin vim
*.opin vom
*.ipin track
*.iopin vss
*.iopin vdd
XMp vip vgp vop vss sg13_lv_nmos w={w/nf} l={l} ng=1 m=nf
Cp vop vss {cl} m=1
XMm vim track vom vss sg13_lv_nmos w={w/nf} l={l} ng=1 m=nf
Cm vom vss {cl} m=1
Cm1 vtop vbot {cb} m=1
S1 vbot vss ph vss SW1
S2 vdd vtop ph vss SW1
S3 vgp vtop pt vss SW1
S4 vip vbot pt vss SW1
x1 track VDD VSS trackb sg13g2_inv_2
S5 vss vgp ph vss SW1
x2 trackb net1 VDD VSS net2 sg13g2_nand2_2
x3 net2 track VDD VSS net1 sg13g2_nand2_2
x4 net2 VDD VSS ph sg13g2_inv_2
x5 net1 VDD VSS pt sg13g2_inv_2
XMdum net3 net4 net3 vss sg13_lv_nmos w={w/nf} l={l} ng=1 m=nf
V1 net3 vss vcm
V2 net4 net3 vdd
Cp1 ph vss 10f m=1
Cp2 pt vss 10f m=1
.ends

.GLOBAL GND
**** begin user architecture code
.MODEL SW1 SW
+ VT=0.6 VH=0.1
+ RON=1 ROFF=10G
**** end user architecture code
.end
