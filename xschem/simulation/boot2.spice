** sch_path: /foss/designs/ICONS2026/xschem/boot2.sch
**.subckt boot2 vdd p1 p2 vo vi
*.ipin vi
*.opin vo
*.ipin p2
*.ipin p1
*.iopin vdd
Cm1 vtop vbot cb m=1
S1 vbot GND p2 GND SW1
S2 vdd vtop p2 GND SW1
S3 vg vtop p1 GND SW1
S4 vi vbot p1 GND SW1
XM1 vi vg vo GND sg13_lv_nmos w=w l=0.13u ng=ng m=1
XM8 GND vdd net1 GND sg13_lv_nmos w=w4 l=0.13u ng=ng4 m=1
XM4 net1 p2 GND GND sg13_lv_nmos w=w4 l=0.13u ng=ng4 m=1
S5 vg GND p2 GND SW1
**.ends
.GLOBAL GND
**** begin user architecture code
.MODEL SW1 SW
+ VT=0.6 VH=vh
+ RON=rsw ROFF=roff
**** end user architecture code
.end
